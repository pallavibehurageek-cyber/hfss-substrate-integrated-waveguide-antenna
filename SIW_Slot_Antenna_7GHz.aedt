# Ansys Electronics Desktop project, version 2024.1
materials:
  vacuum: permittivity=1
  Rogers RT/duroid 5870 (tm): permittivity=2.33 dielectric_loss_tangent=0.0012
  Duroid (tm): permittivity=2.2 dielectric_loss_tangent=0.0009
  pec: conductivity=1e+30
  air: permittivity=1.0006 permeability=1.0000004

design HFSSDesign1 (HFSS, HFSS Terminal Network, model units mm)
geometry:
  SUBSTRATE [Duroid (tm)] = box(corner=(-17mm, -17mm, 0mm), size=(34mm, 34mm, 0.787mm))
  Ground_Plane [pec] = box(corner=(-17mm, -17mm, 0mm), size=(34mm, 34mm, -0.017mm))
  Patch = box(corner=(-12mm, -12mm, 0.787mm), size=(24mm, 24mm, 0.017mm))
  Via_22_11_11 = imported_body()
  PORT = rectangle(corner=(17mm, -1.165mm, 0mm), y_size=2.33mm, z_size=0.787mm)
  Feedline [pec] = box(corner=(12mm, -1.165mm, 0.787mm), size=(5mm, 2.33mm, 0.017mm))
  Via_22_11_11_1 [pec] = Via_22_11_11.duplicate_around_axis(axis=Y, angle=360deg, total=2)
  SUBSTRATE.subtract(Via_22_11_11)
  Radiation [air] = box(corner=(-40mm, -40mm, -5mm), size=(80mm, 80mm, 40mm))
  Feedline.unite(Patch)
  SLOT = box(corner=(-1mm, -6mm, 0.787mm), size=(2mm, 12mm, 0.017mm))
  Feedline.subtract(SLOT)
  Box1 = box(corner=(12mm, -1.165mm, 0.787mm), size=(-3mm, -0.5mm, 0.017mm))
  Box2 = box(corner=(12mm, 1.165mm, 0.787mm), size=(-3mm, 0.5mm, 0.017mm))
  Box1.unite(Box2)
  Feedline.subtract(Box1)
boundaries and excitations:
  Rad1: Radiation Objects=Radiation
  1: Lumped Port Objects=PORT LumpedPortType=Modal Modes{Mode1{IntLine{(17, 0, 0) -> (17, 0, 0.787)} CharImp=Zpi}} Impedance=50ohm
setups:
  Setup1: HfssDriven Frequency=8GHz MaxDeltaS=0.02 MaximumPasses=6 MinimumPasses=1 MinimumConvergedPasses=1 PercentRefinement=30 BasisOrder=1 PortAccuracy=2 DrivenSolverType="Direct Solver"
    sweep Sweep: 5GHz to 12GHz step 0.1GHz; Type=Fast SaveFields
source amplitudes:
  1:1: 1V 0deg
radiation setups:
  Infinite Sphere1: Infinite Sphere Theta=-180deg..180deg step 2deg Phi=0deg..180deg step 2deg
field plots:
  ComplexMag_Jsurf1: Jsurf over Feedline.face(all 18) on Setup1 : LastAdaptive at Freq=8GHz Phase=0deg
reports:
  Terminal S Parameter Plot 1: dB(St(1,1)) vs Freq on Setup1 : Sweep; markers m1 at 7.9GHz
  Terminal VSWR Plot 1: VSWRt(1) vs Freq on Setup1 : Sweep
  Gain Plot 1: dB(GainPhi), dB(GainTheta) vs Theta on Setup1 : LastAdaptive, Infinite Sphere1 [Phi=all Freq=8GHz]
  Gain Plot 2: dB(GainPhi), dB(GainTheta) vs Theta on Setup1 : LastAdaptive, Infinite Sphere1 [Phi=0deg,90deg Freq=8GHz]
